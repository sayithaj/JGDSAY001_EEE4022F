# Ansys Electronics Desktop project, version 2020.2
materials:
  vacuum: permittivity=1
  copper: permeability=0.999991 conductivity=58000000
  ferrite78: permittivity=12 permeability=1680 conductivity=0.01
  perfect conductor: conductivity=1e+30
  PV_ETFE: permittivity=2.6 conductivity=1e-14 dielectric_loss_tangent=0.001
  PV_Aluminium: conductivity=33000000
  PV_EVA: permittivity=2.9 conductivity=1e-14 dielectric_loss_tangent=0.01
  PV_Silicon: permittivity=11.7 conductivity=55 dielectric_loss_tangent=0.001
  PV_PET: permittivity=3 conductivity=1e-14 dielectric_loss_tangent=0.02
  PV_Glass: permittivity=6.5 conductivity=1e-12 dielectric_loss_tangent=0.001

design Maxwell3DDesign1 (Maxwell 3D, EddyCurrent, model units mm)
geometry:
  Frame [PV_Aluminium] = imported_body(C:\Users\Sayitha\Documents\UCT\EEE4022F\Simulations\PV_workbench\PV_step.stp)
  EVA_1 [PV_EVA] = imported_body(C:\Users\Sayitha\Documents\UCT\EEE4022F\Simulations\PV_workbench\PV_step.stp)
  Solar_Glass [PV_Glass] = imported_body(C:\Users\Sayitha\Documents\UCT\EEE4022F\Simulations\PV_workbench\PV_step.stp)
  EVA_2 [PV_EVA] = imported_body(C:\Users\Sayitha\Documents\UCT\EEE4022F\Simulations\PV_workbench\PV_step.stp)
  ETFE [PV_ETFE] = imported_body(C:\Users\Sayitha\Documents\UCT\EEE4022F\Simulations\PV_workbench\PV_step.stp)
  Backsheet [PV_PET] = imported_body(C:\Users\Sayitha\Documents\UCT\EEE4022F\Simulations\PV_workbench\PV_step.stp)
  Cell_2..Cell_6, Cell_1, Cell, Cell_9, Cell_8, Cell_7, Cell_12, Cell_13, Cell_15, Cell_14, Cell_16, Cell_17, Cell_19, Cell_18, Cell_20..Cell_24, Cell_26, Cell_25, Cell_28, Cell_27, Cell_30, Cell_29, Cell_31..Cell_34, Cell_36, Cell_35, Cell_37..Cell_40, Cell_42, Cell_41, Cell_11, Cell_10, Cell_44, Cell_43, Cell_45, Cell_46, Cell_48, Cell_47, Cell_49, Cell_50, Cell_52, Cell_51, Cell_54, Cell_53, Cell_56, Cell_55, Cell_58, Cell_57, Cell_60, Cell_59, Cell_61, Cell_63, Cell_62, Cell_65, Cell_64, Cell_67, Cell_66, Cell_68, Cell_69, Cell_71, Cell_70 [PV_Silicon] = imported_body(C:\Users\Sayitha\Documents\UCT\EEE4022F\Simulations\PV_workbench\PV_step.stp)
  [Frame, EVA_1, Solar_Glass, EVA_2, ETFE, Backsheet, Cell_2..Cell_6, Cell_1, Cell, Cell_9, Cell_8, Cell_7, Cell_12, Cell_13, Cell_15, Cell_14, Cell_16, Cell_17, Cell_19, Cell_18, Cell_20..Cell_24, Cell_26, Cell_25, Cell_28, Cell_27, Cell_30, Cell_29, Cell_31..Cell_34, Cell_36, Cell_35, Cell_37..Cell_40, Cell_42, Cell_41, Cell_11, Cell_10, Cell_44, Cell_43, Cell_45, Cell_46, Cell_48, Cell_47, Cell_49, Cell_50, Cell_52, Cell_51, Cell_54, Cell_53, Cell_56, Cell_55, Cell_58, Cell_57, Cell_60, Cell_59, Cell_61, Cell_63, Cell_62, Cell_65, Cell_64, Cell_67, Cell_66, Cell_68, Cell_69, Cell_71, Cell_70].rotate(axis=X, angle=90deg)
  [Frame, EVA_1, Solar_Glass, EVA_2, ETFE, Backsheet, Cell_2..Cell_6, Cell_1, Cell, Cell_9, Cell_8, Cell_7, Cell_12, Cell_13, Cell_15, Cell_14, Cell_16, Cell_17, Cell_19, Cell_18, Cell_20..Cell_24, Cell_26, Cell_25, Cell_28, Cell_27, Cell_30, Cell_29, Cell_31..Cell_34, Cell_36, Cell_35, Cell_37..Cell_40, Cell_42, Cell_41, Cell_11, Cell_10, Cell_44, Cell_43, Cell_45, Cell_46, Cell_48, Cell_47, Cell_49, Cell_50, Cell_52, Cell_51, Cell_54, Cell_53, Cell_56, Cell_55, Cell_58, Cell_57, Cell_60, Cell_59, Cell_61, Cell_63, Cell_62, Cell_65, Cell_64, Cell_67, Cell_66, Cell_68, Cell_69, Cell_71, Cell_70].move(-627mm, 281mm, 0mm)
  [Frame, EVA_1, Solar_Glass, EVA_2, ETFE, Backsheet, Cell_2..Cell_6, Cell_1, Cell, Cell_9, Cell_8, Cell_7, Cell_12, Cell_13, Cell_15, Cell_14, Cell_16, Cell_17, Cell_19, Cell_18, Cell_20..Cell_24, Cell_26, Cell_25, Cell_28, Cell_27, Cell_30, Cell_29, Cell_31..Cell_34, Cell_36, Cell_35, Cell_37..Cell_40, Cell_42, Cell_41, Cell_11, Cell_10, Cell_44, Cell_43, Cell_45, Cell_46, Cell_48, Cell_47, Cell_49, Cell_50, Cell_52, Cell_51, Cell_54, Cell_53, Cell_56, Cell_55, Cell_58, Cell_57, Cell_60, Cell_59, Cell_61, Cell_63, Cell_62, Cell_65, Cell_64, Cell_67, Cell_66, Cell_68, Cell_69, Cell_71, Cell_70].move(0mm, 0mm, 5.4mm)
  Region [vacuum] = region(percentage_offset=400 on all sides)
  Rectangle2_11 [copper] = rectangle(corner=(0mm, 0mm, 0mm), z_size=2mm, x_size=2mm)
  Rectangle2_11.move(28mm, 0mm, 0mm)
  Rectangle2_12..Rectangle2_22 [copper] = Rectangle2_11.duplicate_along_line(step=(2.2mm, 0mm, 0mm), total=12)
  Rectangle2_11.sweep_around_axis(axis=Z, angle=360deg)
  Rectangle2_11.move(0mm, 0mm, -2mm)
  Rectangle2_11_Section1 [copper] = Rectangle2_11.section(plane=YZ)
  Rectangle2_12.sweep_around_axis(axis=Z, angle=360deg)
  Rectangle2_12.move(0mm, 0mm, -2mm)
  Rectangle2_12_Section1 [copper] = Rectangle2_12.section(plane=YZ)
  Rectangle2_13.sweep_around_axis(axis=Z, angle=360deg)
  Rectangle2_13.move(0mm, 0mm, -2mm)
  Rectangle2_13_Section1 [copper] = Rectangle2_13.section(plane=YZ)
  Rectangle2_14.sweep_around_axis(axis=Z, angle=360deg)
  Rectangle2_14.move(0mm, 0mm, -2mm)
  Rectangle2_14_Section1 [copper] = Rectangle2_14.section(plane=YZ)
  Rectangle2_15.sweep_around_axis(axis=Z, angle=360deg)
  Rectangle2_15.move(0mm, 0mm, -2mm)
  Rectangle2_15_Section1 [copper] = Rectangle2_15.section(plane=YZ)
  Rectangle2_16.sweep_around_axis(axis=Z, angle=360deg)
  Rectangle2_16.move(0mm, 0mm, -2mm)
  Rectangle2_16_Section1 [copper] = Rectangle2_16.section(plane=YZ)
  Rectangle2_17.sweep_around_axis(axis=Z, angle=360deg)
  Rectangle2_17.move(0mm, 0mm, -2mm)
  Rectangle2_17_Section1 [copper] = Rectangle2_17.section(plane=YZ)
  Rectangle2_18.sweep_around_axis(axis=Z, angle=360deg)
  Rectangle2_18.move(0mm, 0mm, -2mm)
  Rectangle2_18_Section1 [copper] = Rectangle2_18.section(plane=YZ)
  Rectangle2_19.sweep_around_axis(axis=Z, angle=360deg)
  Rectangle2_19.move(0mm, 0mm, -2mm)
  Rectangle2_19_Section1 [copper] = Rectangle2_19.section(plane=YZ)
  Rectangle2_20.sweep_around_axis(axis=Z, angle=360deg)
  Rectangle2_20.move(0mm, 0mm, -2mm)
  Rectangle2_20_Section1 [copper] = Rectangle2_20.section(plane=YZ)
  Rectangle2_21.sweep_around_axis(axis=Z, angle=360deg)
  Rectangle2_21.move(0mm, 0mm, -2mm)
  Rectangle2_21_Section1 [copper] = Rectangle2_21.section(plane=YZ)
  Rectangle2_22.sweep_around_axis(axis=Z, angle=360deg)
  Rectangle2_22.move(0mm, 0mm, -2mm)
  Rectangle2_22_Section1 [copper] = Rectangle2_22.section(plane=YZ)
  Rectangle1_11 [copper] = rectangle(corner=(0mm, 0mm, 0mm), z_size=2mm, x_size=2mm)
  Rectangle1_11.move(28mm, 0mm, 0mm)
  Rectangle1_12..Rectangle1_22 [copper] = Rectangle1_11.duplicate_along_line(step=(2.2mm, 0mm, 0mm), total=12)
  Rectangle1_11.sweep_around_axis(axis=Z, angle=360deg)
  Rectangle1_11.move(0mm, 0mm, -2mm)
  Rectangle1_11.move(0mm, 0mm, 46mm)
  Rectangle1_11_Section1 [copper] = Rectangle1_11.section(plane=YZ)
  Rectangle1_12.sweep_around_axis(axis=Z, angle=360deg)
  Rectangle1_12.move(0mm, 0mm, -2mm)
  Rectangle1_12.move(0mm, 0mm, 46mm)
  Rectangle1_12_Section1 [copper] = Rectangle1_12.section(plane=YZ)
  Rectangle1_13.sweep_around_axis(axis=Z, angle=360deg)
  Rectangle1_13.move(0mm, 0mm, -2mm)
  Rectangle1_13.move(0mm, 0mm, 46mm)
  Rectangle1_13_Section1 [copper] = Rectangle1_13.section(plane=YZ)
  Rectangle1_14.sweep_around_axis(axis=Z, angle=360deg)
  Rectangle1_14.move(0mm, 0mm, -2mm)
  Rectangle1_14.move(0mm, 0mm, 46mm)
  Rectangle1_14_Section1 [copper] = Rectangle1_14.section(plane=YZ)
  Rectangle1_15.sweep_around_axis(axis=Z, angle=360deg)
  Rectangle1_15.move(0mm, 0mm, -2mm)
  Rectangle1_15.move(0mm, 0mm, 46mm)
  Rectangle1_15_Section1 [copper] = Rectangle1_15.section(plane=YZ)
  Rectangle1_16.sweep_around_axis(axis=Z, angle=360deg)
  Rectangle1_16.move(0mm, 0mm, -2mm)
  Rectangle1_16.move(0mm, 0mm, 46mm)
  Rectangle1_16_Section1 [copper] = Rectangle1_16.section(plane=YZ)
  Rectangle1_17.sweep_around_axis(axis=Z, angle=360deg)
  Rectangle1_17.move(0mm, 0mm, -2mm)
  Rectangle1_17.move(0mm, 0mm, 46mm)
  Rectangle1_17_Section1 [copper] = Rectangle1_17.section(plane=YZ)
  Rectangle1_18.sweep_around_axis(axis=Z, angle=360deg)
  Rectangle1_18.move(0mm, 0mm, -2mm)
  Rectangle1_18.move(0mm, 0mm, 46mm)
  Rectangle1_18_Section1 [copper] = Rectangle1_18.section(plane=YZ)
  Rectangle1_19.sweep_around_axis(axis=Z, angle=360deg)
  Rectangle1_19.move(0mm, 0mm, -2mm)
  Rectangle1_19.move(0mm, 0mm, 46mm)
  Rectangle1_19_Section1 [copper] = Rectangle1_19.section(plane=YZ)
  Rectangle1_20.sweep_around_axis(axis=Z, angle=360deg)
  Rectangle1_20.move(0mm, 0mm, -2mm)
  Rectangle1_20.move(0mm, 0mm, 46mm)
  Rectangle1_20_Section1 [copper] = Rectangle1_20.section(plane=YZ)
  Rectangle1_21.sweep_around_axis(axis=Z, angle=360deg)
  Rectangle1_21.move(0mm, 0mm, -2mm)
  Rectangle1_21.move(0mm, 0mm, 46mm)
  Rectangle1_21_Section1 [copper] = Rectangle1_21.section(plane=YZ)
  Rectangle1_22.sweep_around_axis(axis=Z, angle=360deg)
  Rectangle1_22.move(0mm, 0mm, -2mm)
  Rectangle1_22.move(0mm, 0mm, 46mm)
  Rectangle1_22_Section1 [copper] = Rectangle1_22.section(plane=YZ)
  Rectangle1_11_Section1.separate_bodies()
  Rectangle1_12_Section1.separate_bodies()
  Rectangle1_13_Section1.separate_bodies()
  Rectangle1_14_Section1.separate_bodies()
  Rectangle1_15_Section1.separate_bodies()
  Rectangle1_16_Section1.separate_bodies()
  Rectangle1_17_Section1.separate_bodies()
  Rectangle1_18_Section1.separate_bodies()
  Rectangle1_19_Section1.separate_bodies()
  Rectangle1_20_Section1.separate_bodies()
  Rectangle1_21_Section1.separate_bodies()
  Rectangle1_22_Section1.separate_bodies()
  Rectangle2_11_Section1.separate_bodies()
  Rectangle2_12_Section1.separate_bodies()
  Rectangle2_13_Section1.separate_bodies()
  Rectangle2_14_Section1.separate_bodies()
  Rectangle2_15_Section1.separate_bodies()
  Rectangle2_16_Section1.separate_bodies()
  Rectangle2_17_Section1.separate_bodies()
  Rectangle2_18_Section1.separate_bodies()
  Rectangle2_19_Section1.separate_bodies()
  Rectangle2_20_Section1.separate_bodies()
  Rectangle2_21_Section1.separate_bodies()
  Rectangle2_22_Section1.separate_bodies()
  [Rectangle2_11..Rectangle2_22, Rectangle2_11_Section1, Rectangle2_12_Section1, Rectangle2_13_Section1, Rectangle2_14_Section1, Rectangle2_15_Section1, Rectangle2_16_Section1, Rectangle2_17_Section1, Rectangle2_18_Section1, Rectangle2_19_Section1, Rectangle2_20_Section1, Rectangle2_21_Section1, Rectangle2_22_Section1, Rectangle1_11..Rectangle1_22, Rectangle1_11_Section1, Rectangle1_12_Section1, Rectangle1_13_Section1, Rectangle1_14_Section1, Rectangle1_15_Section1, Rectangle1_16_Section1, Rectangle1_17_Section1, Rectangle1_18_Section1, Rectangle1_19_Section1, Rectangle1_20_Section1, Rectangle1_21_Section1, Rectangle1_22_Section1].move(0mm, 0mm, -52mm)
  group PV_Group = Frame, EVA_1, Solar_Glass, EVA_2, ETFE, Backsheet, Cell_2..Cell_6, Cell_1, Cell, Cell_9, Cell_8, Cell_7, Cell_12, Cell_13, Cell_15, Cell_14, Cell_16, Cell_17, Cell_19, Cell_18, Cell_20..Cell_24, Cell_26, Cell_25, Cell_28, Cell_27, Cell_30, Cell_29, Cell_31..Cell_34, Cell_36, Cell_35, Cell_37..Cell_40, Cell_42, Cell_41, Cell_11, Cell_10, Cell_44, Cell_43, Cell_45, Cell_46, Cell_48, Cell_47, Cell_49, Cell_50, Cell_52, Cell_51, Cell_54, Cell_53, Cell_56, Cell_55, Cell_58, Cell_57, Cell_60, Cell_59, Cell_61, Cell_63, Cell_62, Cell_65, Cell_64, Cell_67, Cell_66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
  group TX = Rectangle2_11..Rectangle2_22, Rectangle2_11_Section1, Rectangle2_12_Section1, Rectangle2_13_Section1, Rectangle2_14_Section1, Rectangle2_15_Section1, Rectangle2_16_Section1, Rectangle2_17_Section1, Rectangle2_18_Section1, Rectangle2_19_Section1, Rectangle2_20_Section1, Rectangle2_21_Section1, Rectangle2_22_Section1
  group RX = Rectangle1_11..Rectangle1_22, Rectangle1_11_Section1, Rectangle1_12_Section1, Rectangle1_13_Section1, Rectangle1_14_Section1, Rectangle1_15_Section1, Rectangle1_16_Section1, Rectangle1_17_Section1, Rectangle1_18_Section1, Rectangle1_19_Section1, Rectangle1_20_Section1, Rectangle1_21_Section1, Rectangle1_22_Section1
boundaries and excitations:
  CoilTerminal_1: Coil Terminal Objects=Rectangle1_11_Section1 Conductor_number=1000 Winding=W1 Point_out_of_terminal=false
  CoilTerminal_2: Coil Terminal Objects=Rectangle1_12_Section1 Conductor_number=1000 Winding=W1 Point_out_of_terminal=false
  CoilTerminal_3: Coil Terminal Objects=Rectangle1_13_Section1 Conductor_number=1000 Winding=W1 Point_out_of_terminal=false
  CoilTerminal_4: Coil Terminal Objects=Rectangle1_14_Section1 Conductor_number=1000 Winding=W1 Point_out_of_terminal=false
  CoilTerminal_5: Coil Terminal Objects=Rectangle1_15_Section1 Conductor_number=1000 Winding=W1 Point_out_of_terminal=false
  CoilTerminal_6: Coil Terminal Objects=Rectangle1_16_Section1 Conductor_number=1000 Winding=W1 Point_out_of_terminal=false
  CoilTerminal_7: Coil Terminal Objects=Rectangle1_17_Section1 Conductor_number=1000 Winding=W1 Point_out_of_terminal=false
  CoilTerminal_8: Coil Terminal Objects=Rectangle1_18_Section1 Conductor_number=1000 Winding=W1 Point_out_of_terminal=false
  CoilTerminal_9: Coil Terminal Objects=Rectangle1_19_Section1 Conductor_number=1000 Winding=W1 Point_out_of_terminal=false
  CoilTerminal_10: Coil Terminal Objects=Rectangle1_20_Section1 Conductor_number=1000 Winding=W1 Point_out_of_terminal=false
  CoilTerminal_11: Coil Terminal Objects=Rectangle1_21_Section1 Conductor_number=1000 Winding=W1 Point_out_of_terminal=false
  CoilTerminal_12: Coil Terminal Objects=Rectangle1_22_Section1 Conductor_number=1000 Winding=W1 Point_out_of_terminal=false
  CoilTerminal_13: Coil Terminal Objects=Rectangle2_11_Section1 Conductor_number=1000 Winding=W2 Point_out_of_terminal=false
  CoilTerminal_14: Coil Terminal Objects=Rectangle2_12_Section1 Conductor_number=1000 Winding=W2 Point_out_of_terminal=false
  CoilTerminal_15: Coil Terminal Objects=Rectangle2_13_Section1 Conductor_number=1000 Winding=W2 Point_out_of_terminal=false
  CoilTerminal_16: Coil Terminal Objects=Rectangle2_14_Section1 Conductor_number=1000 Winding=W2 Point_out_of_terminal=false
  CoilTerminal_17: Coil Terminal Objects=Rectangle2_15_Section1 Conductor_number=1000 Winding=W2 Point_out_of_terminal=false
  CoilTerminal_18: Coil Terminal Objects=Rectangle2_16_Section1 Conductor_number=1000 Winding=W2 Point_out_of_terminal=false
  CoilTerminal_19: Coil Terminal Objects=Rectangle2_17_Section1 Conductor_number=1000 Winding=W2 Point_out_of_terminal=false
  CoilTerminal_20: Coil Terminal Objects=Rectangle2_18_Section1 Conductor_number=1000 Winding=W2 Point_out_of_terminal=false
  CoilTerminal_21: Coil Terminal Objects=Rectangle2_19_Section1 Conductor_number=1000 Winding=W2 Point_out_of_terminal=false
  CoilTerminal_22: Coil Terminal Objects=Rectangle2_20_Section1 Conductor_number=1000 Winding=W2 Point_out_of_terminal=false
  CoilTerminal_23: Coil Terminal Objects=Rectangle2_21_Section1 Conductor_number=1000 Winding=W2 Point_out_of_terminal=false
  CoilTerminal_24: Coil Terminal Objects=Rectangle2_22_Section1 Conductor_number=1000 Winding=W2 Point_out_of_terminal=false
  W1: Winding Group Type=Current IsSolid=false Current=1mA ParallelBranchesNum=1 Phase=0deg
  W2: Winding Group Type=Current IsSolid=false Current=1mA ParallelBranchesNum=1 Phase=90deg
parameters:
  Matrix1: Matrix W1, W2:
mesh:
  Reg: LengthBased RefineInside Objects=Region NumMaxElem=10000
  Frame: LengthBased RefineInside Objects=Frame NumMaxElem=10000
  etfe: LengthBased RefineInside Objects=ETFE NumMaxElem=10000
  EVA: LengthBased RefineInside Objects=[EVA_1, EVA_2] NumMaxElem=10000
  Glass: LengthBased RefineInside Objects=Solar_Glass NumMaxElem=10000
  PET: LengthBased RefineInside Objects=Backsheet NumMaxElem=10000
  Si: LengthBased RefineInside Objects=[Cell, Cell_1..Cell_71] NumMaxElem=10000
  Rx: LengthBased Objects=[Rectangle1_11..Rectangle1_22] NumMaxElem=10000
  Tx: LengthBased Objects=[Rectangle2_11..Rectangle2_22] NumMaxElem=10000
  initial mesh: GlobalCurvilinear{Apply}
setups:
  Setup1: EddyCurrent MaximumPasses=10 MinimumPasses=2 MinimumConvergedPasses=1 PercentRefinement=30 PercentError=1 NonLinearResidual=0.0001 Frequency=60Hz SweepSetupType=LinearStep StartValue=7.5e-05GHz StopValue=120kHz StepSize=5kHz SaveAllFields
field plots:
  Mag_B1: B over a plane on Setup1 : LastAdaptive at Freq=6e-08GHz Phase=0deg
reports:
  L Plot 1: Matrix1.L(W1,W1), Matrix1.L(W2,W1) vs Freq on Setup1 : LastAdaptive
  Winding Plot 1: re(FluxLinkage(W1)), re(FluxLinkage(W2)) vs Freq on Setup1 : LastAdaptive
  Winding Plot 2: re(InducedVoltage(W1)), re(InputCurrent(W1)), re(InducedVoltage(W2)), re(InputCurrent(W2)) vs Freq on Setup1 : LastAdaptive
  Loss Plot 1: SolidLoss vs Freq on Setup1 : LastAdaptive
  L Table 1: Matrix1.L(W1,W1), Matrix1.L(W2,W1), Matrix1.L(W1,W2), Matrix1.L(W2,W2) vs Freq on Setup1 : LastAdaptive
  Coupling Coeff Table 1: Matrix1.CplCoef(W1,W1), Matrix1.CplCoef(W2,W1), Matrix1.CplCoef(W1,W2), Matrix1.CplCoef(W2,W2) vs Freq on Setup1 : LastAdaptive
  R Table 1: Matrix1.R(W1,W1), Matrix1.R(W2,W1), Matrix1.R(W1,W2), Matrix1.R(W2,W2) vs Freq on Setup1 : LastAdaptive
  Loss Table 1: SolidLoss vs Freq on Setup1 : LastAdaptive
